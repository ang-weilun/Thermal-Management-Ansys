# Ansys Electronics Desktop project, version 2024.2
project datasets:
  $Ceramic_material_39: (-273.15, 0.067032967) (-196.15, 0.067032967) (99.85, 1) (726.85, 1)
materials:
  air: permittivity=1.0006 permeability=1.0000004 thermal_conductivity=0.0261 mass_density=1.1614 specific_heat=1005 thermal_expansion_coefficient=0.00333 thermal_material_type=Fluid diffusivity=2.88e-05 molecular_mass=0.028966 viscosity=1.84e-05
  copper: permittivity=1 permeability=0.999991 conductivity=58000000 thermal_conductivity=387.6 mass_density=8933 specific_heat=397
  FR4_epoxy: permittivity=4.4 permeability=1 dielectric_loss_tangent=0.02
  ODB_DIEL_dielectric_1: permittivity=4.6 dielectric_loss_tangent=0.02 thermal_conductivity=0.35 mass_density=1250 specific_heat=1300
  ODB_DIEL_dielectric_2: permittivity=4.5 dielectric_loss_tangent=0.02 thermal_conductivity=0.35 mass_density=1250 specific_heat=1300
  ODB_DIEL_top_layer: permittivity=1
  ODB_DIEL_top_solder: permittivity=3.5 thermal_conductivity=0.35 mass_density=1250 specific_heat=1300
  Al-Extruded: thermal_conductivity=205 mass_density=2800 specific_heat=900 youngs_modulus=69000000000 poissons_ratio=0.33 thermal_expansion_coefficient=2.277e-06 thermal_material_type=Solid
  Ceramic_material: thermal_modifier{Property=specific_heat free_form_value=pwl($Ceramic_material_39,Temp)} thermal_conductivity=15 mass_density=3970 specific_heat=910 thermal_material_type=Solid
surface materials:
  Steel-oxidised-surface: surface_emissivity=0.8
  Non-Metallic Paint-surface: surface_emissivity=0.9

design IcepakDesign1 (Icepak, SteadyState TemperatureAndFlow, model units mm)
options: Default_Fluid_Material=air Default_Solid_Material=Al-Extruded Default_Surface_Material=Steel-oxidised-surface AmbientTemperature=20cel AmbientPressure=0n_per_meter_sq AmbientRadiationTemperature=20cel Gravity_Vector_CS_ID=Global Gravity_Vector_Axis=Z Positive=false Altitude=0meter OperatingPressure=101325n_per_meter_sq OperatingDensity=1.225kg_per_m3
geometry:
  Region [air] = region(percentage_offset=50 on all sides)
  PCB1_1 = component(PCB1, Type=PCB Unit=mm MovePlane=XY ExtentsType=Polygon OutlinePolygon=poly__951 BoardCutoutMaterial=air ViaHoleMaterial=copper PartsChoice=0 BBoxPolygon("cw=false", "cl=true", "pt(U='mm', x=29.25, y=0, x=100, y=0, x=100, y=75, x=29.25, y=75, x=29.25, y=0)") OutlinePolygonID=951 OutlinePolys{OneOutlinePoly{EDBUId=951 polyname=poly__951 outlinepoly("cw=false", "cl=true", "pt(U='mm', x=29.25, y=0, x=100, y=0, x=100, y=75, x=29.25, y=75, x=29.25, y=0)")}} EdbLayerInfoMap{oneLayerInfo{LayerIndex=0 LayerName=top_solder LayerMaterial=ODB_DIEL_top_solder Thickness=0.4mil LayerLowerElevation=1.523442mm LayerType=1 3D_Layout_Model_Unit=36} oneLayerInfo{LayerIndex=1 LayerName=top_layer LayerMaterial=copper Thickness=1.4mil LayerLowerElevation=1.487882mm LayerType=0 3D_Layout_Model_Unit=36} oneLayerInfo{LayerIndex=2 LayerName=dielectric_2 LayerMaterial=ODB_DIEL_dielectric_2 Thickness=8.2mil LayerLowerElevation=1.279602mm LayerType=1 3D_Layout_Model_Unit=36} oneLayerInfo{LayerIndex=3 LayerName=vb+ LayerMaterial=copper Thickness=0.68901575mil LayerLowerElevation=1.262101mm LayerType=0 3D_Layout_Model_Unit=36} oneLayerInfo{LayerIndex=4 LayerName=dielectric_1 LayerMaterial=ODB_DIEL_dielectric_1 Thickness=39mil LayerLowerElevation=0.271501mm LayerType=1 3D_Layout_Model_Unit=36} oneLayerInfo{LayerIndex=5 LayerName=gnd LayerMaterial=copper Thickness=0.68901575mil LayerLowerElevation=0.254mm LayerType=0 3D_Layout_Model_Unit=36} oneLayerInfo{LayerIndex=6 LayerName=dielectric_3 LayerMaterial=ODB_DIEL_d)
  PCB1_008_bottom_solder_Outline [ODB_DIEL_top_solder] = part_of(PCB1_1)
  PCB1_000_top_solder_Outline [ODB_DIEL_top_solder, surface Non-Metallic Paint-surface] = part_of(PCB1_1)
  PCB1_001_top_layer_Outline [copper] = part_of(PCB1_1)
  PCB1_002_dielectric_2_Outline [ODB_DIEL_dielectric_2] = part_of(PCB1_1)
  PCB1_003_vb_Outline [copper] = part_of(PCB1_1)
  PCB1_004_dielectric_1_Outline [ODB_DIEL_dielectric_1] = part_of(PCB1_1)
  PCB1_005_gnd_Outline [copper] = part_of(PCB1_1)
  PCB1_006_dielectric_3_Outline [ODB_DIEL_dielectric_2] = part_of(PCB1_1)
  PCB1_007_bottom_layer_Outline [copper] = part_of(PCB1_1)
  C5 [Ceramic_material] = box(corner=(67.9769mm, 13.3484mm, 1.5133mm), size=(6.5032mm, 8.2032mm, 0.254mm))
  U6 [Ceramic_material] = box(corner=(56.0284mm, 28mm, 0mm), size=(5mm, 6mm, -1.76mm))
  U1 [Ceramic_material] = box(corner=(55.7034mm, 45.1mm, 0mm), size=(5mm, 6mm, -1.76mm))
  Q4 [Ceramic_material] = box(corner=(63.1284mm, 22.4499mm, 1.5133mm), size=(16.2001mm, 14.1999mm, 3.5mm))
  Q2 [Ceramic_material] = box(corner=(63.1284mm, 39.4499mm, 1.5133mm), size=(16.2001mm, 14.1999mm, 3.5mm))
  J5 [Ceramic_material, non-model] = box(corner=(86.875mm, 14.825mm, 1.5133mm), size=(12.5mm, 13.3mm, 26.5mm))
  J3 [Ceramic_material, non-model] = box(corner=(86.875mm, 47.975mm, 1.5133mm), size=(12.5mm, 13.3mm, 26.5mm))
  J1 [Ceramic_material, non-model] = box(corner=(86.875mm, 32.325mm, 1.5133mm), size=(12.5mm, 13.3mm, 26.5mm))
  VR2 [Ceramic_material, non-model] = box(corner=(34.8385mm, 29.15mm, 0mm), size=(4.23mm, 3.2mm, -2.5mm))
  VR1 [Ceramic_material] = box(corner=(42.7885mm, 50.65mm, 0mm), size=(4.23mm, 3.2mm, -2.5mm))
  U7 [Ceramic_material] = box(corner=(52.6895mm, 23.6927mm, 0mm), size=(2.921mm, 2.5146mm, -0.9779mm))
  U3 [Ceramic_material] = box(corner=(52.2895mm, 41.1427mm, 0mm), size=(2.921mm, 2.5146mm, -0.9779mm))
  U5 [Ceramic_material] = box(corner=(35.2001mm, 37.45mm, 0mm), size=(2.1998mm, 2mm, -1.101mm))
  U2 [Ceramic_material] = box(corner=(35.1001mm, 41.95mm, 0mm), size=(2.1998mm, 2mm, -1.101mm))
  U4 [Ceramic_material] = box(corner=(37.3mm, 26.255mm, 0mm), size=(3.9mm, 4.89mm, -1.68mm))
  R39 [Ceramic_material] = box(corner=(63.6mm, 22.8mm, 0mm), size=(1.65mm, 0.95mm, -0.5mm))
  R37 [Ceramic_material] = box(corner=(62.225mm, 24.8mm, 0mm), size=(1.65mm, 0.95mm, -0.5mm))
  R29 [Ceramic_material] = box(corner=(64.425mm, 40.5mm, 0mm), size=(1.65mm, 0.95mm, -0.5mm))
  R27 [Ceramic_material] = box(corner=(61.925mm, 41.85mm, 0mm), size=(1.65mm, 0.95mm, -0.5mm))
  R35 [Ceramic_material] = box(corner=(65.125mm, 26.125mm, 0mm), size=(1.55mm, 0.85mm, -0.55mm))
  R25 [Ceramic_material] = box(corner=(64.7mm, 43.15mm, 0mm), size=(1.55mm, 0.85mm, -0.55mm))
  R34 [Ceramic_material] = box(corner=(62.275mm, 26.125mm, 0mm), size=(1.55mm, 0.85mm, -0.5001mm))
  R24 [Ceramic_material] = box(corner=(61.95mm, 43.175mm, 0mm), size=(1.55mm, 0.85mm, -0.5001mm))
  R31 [Ceramic_material] = box(corner=(60.175mm, 25.175mm, 0mm), size=(0.95mm, 1.65mm, -0.5mm))
  R21 [Ceramic_material] = box(corner=(59.725mm, 42.275mm, 0mm), size=(0.95mm, 1.65mm, -0.5mm))
  R30 [Ceramic_material, non-model] = box(corner=(43.675mm, 30.15mm, 0mm), size=(1.55mm, 0.85mm, -0.5001mm))
  R10 [Ceramic_material, non-model] = box(corner=(79.2535mm, 55.535mm, 1.5133mm), size=(1.45mm, 2.2mm, 0.5mm))
  R9 [Ceramic_material, non-model] = box(corner=(77.4475mm, 55.535mm, 1.5133mm), size=(1.45mm, 2.2mm, 0.5mm))
  R8 [Ceramic_material, non-model] = box(corner=(75.6415mm, 55.535mm, 1.5133mm), size=(1.45mm, 2.2mm, 0.5mm))
  R7 [Ceramic_material, non-model] = box(corner=(73.8355mm, 55.535mm, 1.5133mm), size=(1.45mm, 2.2mm, 0.5mm))
  R6 [Ceramic_material, non-model] = box(corner=(72.0295mm, 55.535mm, 1.5133mm), size=(1.45mm, 2.2mm, 0.5mm))
  R5 [Ceramic_material, non-model] = box(corner=(70.2235mm, 55.535mm, 1.5133mm), size=(1.45mm, 2.2mm, 0.5mm))
  R4 [Ceramic_material, non-model] = box(corner=(68.4175mm, 55.535mm, 1.5133mm), size=(1.45mm, 2.2mm, 0.5mm))
  R3 [Ceramic_material, non-model] = box(corner=(66.6115mm, 55.535mm, 1.5133mm), size=(1.45mm, 2.2mm, 0.5mm))
  R2 [Ceramic_material, non-model] = box(corner=(64.8055mm, 55.535mm, 1.5133mm), size=(1.45mm, 2.2mm, 0.5mm))
  R1 [Ceramic_material, non-model] = box(corner=(62.9995mm, 55.535mm, 1.5133mm), size=(1.45mm, 2.2mm, 0.5mm))
  MP4 [Ceramic_material] = box(corner=(79.9565mm, 60.9752mm, 1.5133mm), size=(4.3436mm, 4.3499mm, 2.4mm))
  MP3 [Ceramic_material] = box(corner=(79.9565mm, 10.1752mm, 1.5133mm), size=(4.3436mm, 4.3499mm, 2.4mm))
  MP2 [Ceramic_material, non-model] = box(corner=(54.4465mm, 60.9752mm, 1.5133mm), size=(4.3436mm, 4.3499mm, 2.4mm))
  MP1 [Ceramic_material] = box(corner=(54.4465mm, 10.1752mm, 1.5133mm), size=(4.3436mm, 4.3499mm, 2.4mm))
  L1 [Ceramic_material, non-model] = box(corner=(35.15mm, 33.1238mm, 0mm), size=(8.2mm, 11.6523mm, -4.8mm))
  J4 [Ceramic_material, non-model] = box(corner=(45.34mm, 9.053mm, 1.5133mm), size=(5.08mm, 5.842mm, 13.589mm))
  J2 [Ceramic_material] = box(corner=(38.1808mm, 9.2297mm, 1.5133mm), size=(2.6384mm, 10.0806mm, 0.254mm))
  FL4 [Ceramic_material] = box(corner=(66.825mm, 22.325mm, 0mm), size=(1.2mm, 2mm, -1.401mm))
  FL2 [Ceramic_material] = box(corner=(66.85mm, 39.3mm, 0mm), size=(1.2mm, 2mm, -1.401mm))
  D4 [Ceramic_material, non-model] = box(corner=(45.4375mm, 29.6mm, 0mm), size=(2.475mm, 2.95mm, -1.151mm))
  D1 [Ceramic_material] = box(corner=(44.5875mm, 43.25mm, 0mm), size=(2.475mm, 2.95mm, -1.151mm))
  D3 [Ceramic_material, non-model] = box(corner=(40.7018mm, 29.5053mm, 0mm), size=(1.25mm, 2.4885mm, -0.93mm))
  D2 [Ceramic_material] = box(corner=(48.6518mm, 51.0053mm, 0mm), size=(1.25mm, 2.4885mm, -0.93mm))
  C24 [Ceramic_material] = box(corner=(53.6285mm, 33.3mm, 0mm), size=(1.6mm, 0.8mm, -0.9mm))
  C16 [Ceramic_material] = box(corner=(35.5mm, 35.95mm, 0mm), size=(1.6mm, 0.8mm, -0.9mm))
  C13 [Ceramic_material] = box(corner=(53.1035mm, 50.6mm, 0mm), size=(1.6mm, 0.8mm, -0.9mm))
  C9 [Ceramic_material] = box(corner=(35.4mm, 40.45mm, 0mm), size=(1.6mm, 0.8mm, -0.9mm))
  C23 [Ceramic_material] = box(corner=(56.2mm, 25.25mm, 0mm), size=(0.8mm, 1.6mm, -0.8mm))
  C20 [Ceramic_material] = box(corner=(58.8mm, 25.2mm, 0mm), size=(0.8mm, 1.6mm, -0.8mm))
  C18 [Ceramic_material] = box(corner=(45.8mm, 28.425mm, 0mm), size=(1.6mm, 0.8mm, -0.8mm))
  C17 [Ceramic_material, non-model] = box(corner=(39.95mm, 25.175mm, 0mm), size=(1.6mm, 0.8mm, -0.8mm))
  C15 [Ceramic_material] = box(corner=(44.725mm, 42.125mm, 0mm), size=(1.6mm, 0.8mm, -0.8mm))
  C12 [Ceramic_material] = box(corner=(55.9mm, 42.3mm, 0mm), size=(0.8mm, 1.6mm, -0.8mm))
  C8 [Ceramic_material] = box(corner=(58.55mm, 42.25mm, 0mm), size=(0.8mm, 1.6mm, -0.8mm))
  C22 [Ceramic_material] = box(corner=(65.15mm, 24.95mm, 0mm), size=(1.6mm, 0.8mm, -0.9mm))
  C11 [Ceramic_material] = box(corner=(64.7mm, 42.025mm, 0mm), size=(1.6mm, 0.8mm, -0.9mm))
  C19 [Ceramic_material] = box(corner=(61.6285mm, 32.7mm, 0mm), size=(0.8mm, 1.6mm, -0.87mm))
  C14 [Ceramic_material] = box(corner=(53.1035mm, 49.4mm, 0mm), size=(1.6mm, 0.8mm, -0.87mm))
  C6 [Ceramic_material] = box(corner=(81.3285mm, 55.85mm, 1.5133mm), size=(0.8mm, 1.6mm, 0.87mm))
  C3 [Ceramic_material, non-model] = box(corner=(74.5785mm, 16.55mm, 1.5133mm), size=(2.9mm, 4.6mm, 0.254mm))
  C1 [Ceramic_material, non-model] = box(corner=(43mm, 17.448mm, 1.5133mm), size=(18.5mm, 47.5mm, 18.4635mm))
  group Top_FP_GR355X_0_4_IPC_A_Group = C5
  group Bottom_SOIC127P600X175_8N_10_V_Group = U6, U1
  group Top_SOIC127P1420X350_21N_2_Group = Q4, Q2
  group Top_TE_796740_2_Group = J5, J3, J1
  group Bottom_3313J2102E_Group = VR2, VR1
  group Bottom_DBZ0003A_L_Group = U7, U3
  group Bottom_FP_DCK0005A_MFG_Group = U5, U2
  group Bottom_MAXM_S8E_12_V_Group = U4
  group Bottom_RESC1609X50X30NL10T20_Group = R39, R37, R29, R27
  group Bottom_FP_MCT0603_IPC_C_Group = R35, R25
  group Bottom_FP_CRCW0603_e3_IPC_C_Group = R34, R24
  group Bottom_RESC1609X50X30NL8T20_Group = R31, R21
  group Bottom_FP_CRCW0603_e3_IPC_A_Group = R30
  group Top_RESC2013X50X40NL20T20_Group = R10, R9, R8, R7, R6, R5, R4, R3, R2, R1
  group Top_9774010243_Group = MP4, MP3, MP2, MP1
  group Bottom_B65527B1008T001_Group = L1
  group Top_SHDR2W66P0X254_1X2_508X572X813P_Group = J4
  group Top_FP_4_103185_0_04_MFG_Group = J2
  group Bottom_FP_SRF2012A_MFG_Group = FL4, FL2
  group Bottom_FP_6_541_5014_01_4_MFG_Group = D4, D1
  group Bottom_SOD2512X110N_Group = D3, D2
  group Bottom_FP_CC0603_DA_MFG_Group = C24, C16, C13, C9
  group Bottom_WCAP_CSGP_0603_L1_6W0_8H0_8_Reflow_Group = C23, C20, C18, C17, C15, C12, C8
  group Bottom_FP_GRM188_0_1_e0_2_0_5_IPC_B_Group = C22, C11
  group Bottom_FP_C0603C_CF_MFG_Group = C19, C14
  group Top_FP_C0603C_CF_MFG_Group = C6
  group Top_FP_GCJ32D_0_3_MFG_Group = C3
  group Top_CAPPRD750W80D1800H3750_Group = C1
boundaries and excitations:
  Opening1: Opening Faces=Region.face(+z) Temperature=AmbientTemp External_Rad._Temperature=AmbientRadTemp Inlet_Type=Pressure Total_Pressure=AmbientPressure
  Opening2: Opening Faces=Region.face(-z) Temperature=AmbientTemp External_Rad._Temperature=AmbientRadTemp Inlet_Type=Pressure Total_Pressure=AmbientPressure
  Opening3: Opening Faces=Region.face(-y) Temperature=AmbientTemp External_Rad._Temperature=AmbientRadTemp Inlet_Type=Pressure Total_Pressure=AmbientPressure
  Opening4: Opening Faces=Region.face(+x) Temperature=AmbientTemp External_Rad._Temperature=AmbientRadTemp Inlet_Type=Pressure Total_Pressure=AmbientPressure
  Opening5: Opening Faces=Region.face(+y) Temperature=AmbientTemp External_Rad._Temperature=AmbientRadTemp Inlet_Type=Pressure Total_Pressure=AmbientPressure
  Opening6: Opening Faces=Region.face(-x) Temperature=AmbientTemp External_Rad._Temperature=AmbientRadTemp Inlet_Type=Pressure Total_Pressure=AmbientPressure
  Block1: Block Objects=Q2 Block_Type=Solid Use_Total_Power Total_Power=4W
  Block2: Block Objects=Q4 Block_Type=Solid Use_Total_Power Total_Power=4W
mesh:
  Global:  MeshMethod=MesherHD ComputeGap MeshRegionResolution=3 MinGapX=1mm MinGapY=1mm MinGapZ=1mm Objects=Region FacetLevel=3 ProximitySizeFunction CurvatureSizeFunction OptimizePCBMesh
setups:
  Setup1: IcepakSteadyState Flow_Regime=Laminar Include_Temperature=true Include_Flow=false Include_Gravity Solution_Initialization_-_Z_Velocity=0.010980665m_per_sec Convergence_Criteria_-_Flow=0.001 Convergence_Criteria_-_Energy=1e-09 Convergence_Criteria_-_Discrete_Ordinates=1e-06 GPU_Convergence_Criteria_-_Flow=0.001 GPU_Convergence_Criteria_-_Energy=1e-05 GPU_Convergence_Criteria_-_Discrete_Ordinates=1e-05 Radiation_Model="Discrete Ordinates Model" Flow_Iteration_Per_Radiation_Iteration=10 Time_Step_Interval=1 ThetaDivision=2 PhiDivision=2 ThetaPixels=2 PhiPixels=2 Under-relaxation_-_Pressure=0.7 Under-relaxation_-_Momentum=0.3 Under-relaxation_-_Temperature=1 Discretization_Scheme_-_Pressure=Standard Discretization_Scheme_-_Momentum=First Discretization_Scheme_-_Temperature=First Discretization_Scheme_-_Discrete_Ordinates=First Convergence_Criteria_-_Max_Iterations=100
field plots:
  Temperature1: Temperature over PCB1_008_bottom_solder_Outline, PCB1_000_top_solder_Outline, PCB1_001_top_layer_Outline, PCB1_002_dielectric_2_Outline, PCB1_003_vb_Outline, PCB1_004_dielectric_1_Outline, PCB1_005_gnd_Outline, PCB1_006_dielectric_3_Outline, PCB1_007_bottom_layer_Outline on Setup1 : SteadyState
